* V8 closed loop; DLL port order in README; compile DLL first
.include plant_v8.inc
.include test_normal.inc
* Insert QSPICE C++ instance using the exact line generated by your QSPICE version.
* CONTROL_INSTANCE_PLACEHOLDER
.tran 0 100m 0 10n UIC
.plot V(out) V(ref)
.end
